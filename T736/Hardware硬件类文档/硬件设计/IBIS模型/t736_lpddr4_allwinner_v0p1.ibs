|/***************************************************************************/
|/*   */
|/* Copyright (c) 2020 Synopsys Inc.All rights reserved   */
|/*   */
|/* This Synopsys IP and all associated documentation are proprietary to   */
|/* Synopsys, Inc. and may only be used pursuant to the terms and conditions*/
|/* of a written license agreement with Synopsys, Inc.   */
|/*   */
|/***************************************************************************/
|/*   */
|/* Product:   SSTL IO IBIS model   */
|/*   */
|/***************************************************************************/
[IBIS Ver] 5.1
[File name] t736_lpddr4_allwinner_v0p1.ibs
[Date] 15 Dec 2020
[File Rev] 0.1
[Notes]
[Disclaimer]
[Component] dwc_ddrphy_txbe
[Manufacturer] allwinner
[Package]
|   typ   min   max
R_pkg   0.31856   0.084605   0.48993
L_pkg   2.223e-9   6.95e-10   3.2e-9
C_pkg   9.471e-13   5.762e-13   1.292e-12
[Pin]   Signal_name   model_name   R_pin   L_pin   C_pin
AJ16   SATO   dwc_ddrphy_txbe_PAD   0.24804   1.787e-9   8.416e-13
AJ18   SCA0_A   dwc_ddrphy_txbe_PAD   0.21697   1.617e-9   9.224e-13
AM15   SCA0_B   dwc_ddrphy_txbe_PAD   0.35684   2.317e-9   1.007e-12
AH18   SCA1_A   dwc_ddrphy_txbe_PAD   0.19908   1.501e-9   8.125e-13
AF16   SCA1_B   dwc_ddrphy_txbe_PAD   0.14769   1.054e-9   5.762e-13
AL19   SCA2_A   dwc_ddrphy_txbe_PAD   0.30371   2.118e-9   9.167e-13
AF14   SCA2_B   dwc_ddrphy_txbe_PAD   0.091585   8.054e-10   6.817e-13
AM19   SCA3_A   dwc_ddrphy_txbe_PAD   0.34454   2.453e-9   9.524e-13
AJ12   SCA3_B   dwc_ddrphy_txbe_PAD   0.25685   1.733e-9   8.458e-13
AJ20   SCA4_A   dwc_ddrphy_txbe_PAD   0.25773   1.702e-9   9.036e-13
AM12   SCA4_B   dwc_ddrphy_txbe_PAD   0.35887   2.471e-9   1.003e-12
AH20   SCA5_A   dwc_ddrphy_txbe_PAD   0.23325   1.51e-9   8.279e-13
AL12   SCA5_B   dwc_ddrphy_txbe_PAD   0.31925   2.118e-9   1.009e-12
AF18   SCKE0_A   dwc_ddrphy_txbe_PAD   0.084605   6.95e-10   6.399e-13
AH14   SCKE0_B   dwc_ddrphy_txbe_PAD   0.19627   1.436e-9   6.736e-13
AM17   SCKE1_A   dwc_ddrphy_txbe_PAD   0.36424   2.384e-9   9.96e-13
AJ14   SCKE1_B   dwc_ddrphy_txbe_PAD   0.25643   1.737e-9   7.942e-13
AL18   SCKN_A   dwc_ddrphy_txbe_PAD   0.34986   2.566e-9   9.381e-13
AM13   SCKN_B   dwc_ddrphy_txbe_PAD   0.35676   2.618e-9   9.649e-13
AM18   SCKP_A   dwc_ddrphy_txbe_PAD   0.3427   2.576e-9   9.213e-13
AL13   SCKP_B   dwc_ddrphy_txbe_PAD   0.35025   2.636e-9   9.304e-13
AL17   SCS0_A   dwc_ddrphy_txbe_PAD   0.32274   1.975e-9   1.04e-12
AM14   SCS0_B   dwc_ddrphy_txbe_PAD   0.35569   2.388e-9   9.976e-13
AM16   SCS1_A   dwc_ddrphy_txbe_PAD   0.35242   2.467e-9   9.776e-13
AL14   SCS1_B   dwc_ddrphy_txbe_PAD   0.30426   1.961e-9   1.003e-12
AL25   SDQ0   dwc_ddrphy_txbe_PAD   0.36998   2.369e-9   1.021e-12
AM25   SDQ1   dwc_ddrphy_txbe_PAD   0.41882   2.632e-9   1.113e-12
AH24   SDQ2   dwc_ddrphy_txbe_PAD   0.20634   1.647e-9   8.049e-13
AJ24   SDQ3   dwc_ddrphy_txbe_PAD   0.26072   2.163e-9   9.203e-13
AH26   SDQ4   dwc_ddrphy_txbe_PAD   0.26488   1.721e-9   9.048e-13
AM28   SDQ5   dwc_ddrphy_txbe_PAD   0.426   2.917e-9   1.116e-12
AF24   SDQ6   dwc_ddrphy_txbe_PAD   0.15341   9.95e-10   7.132e-13
AL28   SDQ7   dwc_ddrphy_txbe_PAD   0.39566   2.77e-9   1.073e-12
AM21   SDQ8   dwc_ddrphy_txbe_PAD   0.3639   2.437e-9   1.017e-12
AL20   SDQ9   dwc_ddrphy_txbe_PAD   0.31173   2.086e-9   9.504e-13
AL21   SDQ10   dwc_ddrphy_txbe_PAD   0.33021   2.231e-9   9.727e-13
AM20   SDQ11   dwc_ddrphy_txbe_PAD   0.35181   2.36e-9   1.005e-12
AF22   SDQ12   dwc_ddrphy_txbe_PAD   0.17172   1.203e-9   6.533e-13
AM24   SDQ13   dwc_ddrphy_txbe_PAD   0.3808   2.53e-9   1.039e-12
AJ22   SDQ14   dwc_ddrphy_txbe_PAD   0.27737   1.763e-9   8.699e-13
AL24   SDQ15   dwc_ddrphy_txbe_PAD   0.35092   2.365e-9   1.05e-12
AH12   SDQ16   dwc_ddrphy_txbe_PAD   0.17151   1.363e-9   7.737e-13
AL11   SDQ17   dwc_ddrphy_txbe_PAD   0.31265   2.241e-9   9.904e-13
AJ10   SDQ18   dwc_ddrphy_txbe_PAD   0.22946   1.882e-9   8.739e-13
AM11   SDQ19   dwc_ddrphy_txbe_PAD   0.36039   2.644e-9   9.671e-13
AM8   SDQ20   dwc_ddrphy_txbe_PAD   0.40584   2.655e-9   1.093e-12
AL8   SDQ21   dwc_ddrphy_txbe_PAD   0.37641   2.551e-9   1.029e-12
AH10   SDQ22   dwc_ddrphy_txbe_PAD   0.25517   1.767e-9   8.646e-13
AJ8   SDQ23   dwc_ddrphy_txbe_PAD   0.28184   1.894e-9   9.999e-13
AH8   SDQ24   dwc_ddrphy_txbe_PAD   0.23296   1.585e-9   9.29e-13
AM7   SDQ25   dwc_ddrphy_txbe_PAD   0.42632   2.699e-9   1.125e-12
AL7   SDQ26   dwc_ddrphy_txbe_PAD   0.3999   2.794e-9   1.047e-12
AF10   SDQ27   dwc_ddrphy_txbe_PAD   0.17559   1.223e-9   7.103e-13
AF8   SDQ28   dwc_ddrphy_txbe_PAD   0.20064   1.294e-9   7.315e-13
AM4   SDQ29   dwc_ddrphy_txbe_PAD   0.48993   3.087e-9   1.292e-12
AH6   SDQ30   dwc_ddrphy_txbe_PAD   0.34471   2.04e-9   1.054e-12
AL4   SDQ31   dwc_ddrphy_txbe_PAD   0.46175   2.881e-9   1.182e-12
AJ26   SDQM0   dwc_ddrphy_txbe_PAD   0.32218   2.213e-9   9.884e-13
AH22   SDQM1   dwc_ddrphy_txbe_PAD   0.22148   1.632e-9   7.379e-13
AF12   SDQM2   dwc_ddrphy_txbe_PAD   0.1717   1.138e-9   6.905e-13
AJ6   SDQM3   dwc_ddrphy_txbe_PAD   0.35061   2.143e-9   1.07e-12
AM26   SDQS0N   dwc_ddrphy_txbe_PAD   0.40643   2.995e-9   1.013e-12
AL26   SDQS0P   dwc_ddrphy_txbe_PAD   0.40304   2.948e-9   1.028e-12
AM22   SDQS1N   dwc_ddrphy_txbe_PAD   0.36728   2.724e-9   9.667e-13
AL22   SDQS1P   dwc_ddrphy_txbe_PAD   0.36389   2.702e-9   9.776e-13
AL10   SDQS2N   dwc_ddrphy_txbe_PAD   0.39197   2.908e-9   1.012e-12
AM10   SDQS2P   dwc_ddrphy_txbe_PAD   0.38592   2.904e-9   1.004e-12
AM6   SDQS3N   dwc_ddrphy_txbe_PAD   0.4332   3.124e-9   1.071e-12
AL6   SDQS3P   dwc_ddrphy_txbe_PAD   0.42688   3.081e-9   1.059e-12
AL16   SDTO   dwc_ddrphy_txbe_PAD   0.30655   2.238e-9   9.684e-13
AL15   SRST   dwc_ddrphy_txbe_PAD   0.29689   2.066e-9   9.594e-13
AH16   SZQ   dwc_ddrphy_txbe_PAD   0.22592   1.561e-9   8.318e-13
[Model Selector] dwc_ddrphy_txbe_PAD
txbe_lpd4_25_90   LPDDR4, dwc_ddrphy_txbe_ns, Driver, Z0=90-Ohm at VDDQ/2.5
txbe_lpd4_25_120   LPDDR4, dwc_ddrphy_txbe_ns, Driver, Z0=120-Ohm at VDDQ/2.5
txbe_lpd4_25_180   LPDDR4, dwc_ddrphy_txbe_ns, Driver, Z0=180-Ohm at VDDQ/2.5
txbe_lpd4_25_360   LPDDR4, dwc_ddrphy_txbe_ns, Driver, Z0=360-Ohm at VDDQ/2.5
txbe_lpd4_25_odt60   LPDDR4, dwc_ddrphy_txbe_ns, ODT=60-Ohm at VDDQ/2.5
txbe_lpd4_25_odt80   LPDDR4, dwc_ddrphy_txbe_ns, ODT=80-Ohm at VDDQ/2.5
txbe_lpd4_25_odt120   LPDDR4, dwc_ddrphy_txbe_ns, ODT=120-Ohm at VDDQ/2.5
txbe_lpd4_25_odt240   LPDDR4, dwc_ddrphy_txbe_ns, ODT=240-Ohm at VDDQ/2.5
txbe_lpd4_25_odtoff   LPDDR4, dwc_ddrphy_txbe_ns, ODT=off-Ohm at VDDQ/2.5
txbe_lpd4_3_60   LPDDR4, dwc_ddrphy_txbe_ns, Driver, Z0=60-Ohm at VDDQ/3
txbe_lpd4_3_80   LPDDR4, dwc_ddrphy_txbe_ns, Driver, Z0=80-Ohm at VDDQ/3
txbe_lpd4_3_120   LPDDR4, dwc_ddrphy_txbe_ns, Driver, Z0=120-Ohm at VDDQ/3
txbe_lpd4_3_240   LPDDR4, dwc_ddrphy_txbe_ns, Driver, Z0=240-Ohm at VDDQ/3
txbe_lpd4_3_odt30   LPDDR4, dwc_ddrphy_txbe_ns, ODT=30-Ohm at VDDQ/3
txbe_lpd4_3_odt40   LPDDR4, dwc_ddrphy_txbe_ns, ODT=40-Ohm at VDDQ/3
txbe_lpd4_3_odt60   LPDDR4, dwc_ddrphy_txbe_ns, ODT=60-Ohm at VDDQ/3
txbe_lpd4_3_odt120   LPDDR4, dwc_ddrphy_txbe_ns, ODT=120-Ohm at VDDQ/3
txbe_lpd4_3_odtoff   LPDDR4, dwc_ddrphy_txbe_ns, ODT=off-Ohm at VDDQ/3
txbe_lpd4_25b_90   LPDDR4, dwc_ddrphy_txbe_ns, Boost, Driver, Z0=90-Ohm at VDDQ/2.5
txbe_lpd4_25b_120   LPDDR4, dwc_ddrphy_txbe_ns, Boost, Driver, Z0=120-Ohm at VDDQ/2.5
txbe_lpd4_25b_180   LPDDR4, dwc_ddrphy_txbe_ns, Boost, Driver, Z0=180-Ohm at VDDQ/2.5
txbe_lpd4_25b_360   LPDDR4, dwc_ddrphy_txbe_ns, Boost, Driver, Z0=360-Ohm at VDDQ/2.5
txbe_lpd4_25b_odt60   LPDDR4, dwc_ddrphy_txbe_ns, Boost, ODT=60-Ohm at VDDQ/2.5
txbe_lpd4_25b_odt80   LPDDR4, dwc_ddrphy_txbe_ns, Boost, ODT=80-Ohm at VDDQ/2.5
txbe_lpd4_25b_odt120   LPDDR4, dwc_ddrphy_txbe_ns, Boost, ODT=120-Ohm at VDDQ/2.5
txbe_lpd4_25b_odt240   LPDDR4, dwc_ddrphy_txbe_ns, Boost, ODT=240-Ohm at VDDQ/2.5
txbe_lpd4_25b_odtoff   LPDDR4, dwc_ddrphy_txbe_ns, Boost, ODT=off-Ohm at VDDQ/2.5
txbe_lpd4_3b_60   LPDDR4, dwc_ddrphy_txbe_ns, Boost, Driver, Z0=60-Ohm at VDDQ/3
txbe_lpd4_3b_80   LPDDR4, dwc_ddrphy_txbe_ns, Boost, Driver, Z0=80-Ohm at VDDQ/3
txbe_lpd4_3b_120   LPDDR4, dwc_ddrphy_txbe_ns, Boost, Driver, Z0=120-Ohm at VDDQ/3
txbe_lpd4_3b_240   LPDDR4, dwc_ddrphy_txbe_ns, Boost, Driver, Z0=240-Ohm at VDDQ/3
txbe_lpd4_3b_odt30   LPDDR4, dwc_ddrphy_txbe_ns, Boost, ODT=30-Ohm at VDDQ/3
txbe_lpd4_3b_odt40   LPDDR4, dwc_ddrphy_txbe_ns, Boost, ODT=40-Ohm at VDDQ/3
txbe_lpd4_3b_odt60   LPDDR4, dwc_ddrphy_txbe_ns, Boost, ODT=60-Ohm at VDDQ/3
txbe_lpd4_3b_odt120   LPDDR4, dwc_ddrphy_txbe_ns, Boost, ODT=120-Ohm at VDDQ/3
txbe_lpd4_3b_odtoff   LPDDR4, dwc_ddrphy_txbe_ns, Boost, ODT=off-Ohm at VDDQ/3
| Models and submodels in the file (36): txbe_lpd4_25_120 (I/O), txbe_lpd4_25_180 (I/O), txbe_lpd4_25_360 (I/O), txbe_lpd4_25_90 (I/O), txbe_lpd4_25b_120 (I/O), txbe_lpd4_25b_180 (I/O), txbe_lpd4_25b_360 (I/O), txbe_lpd4_25b_90 (I/O), txbe_lpd4_25b_odt120 (Input), txbe_lpd4_25b_odt240 (Input), txbe_lpd4_25b_odt60 (Input), txbe_lpd4_25b_odt80 (Input), txbe_lpd4_25b_odtoff (Input), txbe_lpd4_25_odt120 (Input), txbe_lpd4_25_odt240 (Input), txbe_lpd4_25_odt60 (Input), txbe_lpd4_25_odt80 (Input), txbe_lpd4_25_odtoff (Input), txbe_lpd4_3_120 (I/O), txbe_lpd4_3_240 (I/O), txbe_lpd4_3_60 (I/O), txbe_lpd4_3_80 (I/O), txbe_lpd4_3b_120 (I/O), txbe_lpd4_3b_240 (I/O), txbe_lpd4_3b_60 (I/O), txbe_lpd4_3b_80 (I/O), txbe_lpd4_3b_odt120 (Input), txbe_lpd4_3b_odt30 (Input), txbe_lpd4_3b_odt40 (Input), txbe_lpd4_3b_odt60 (Input), txbe_lpd4_3b_odtoff (Input), txbe_lpd4_3_odt120 (Input), txbe_lpd4_3_odt30 (Input), txbe_lpd4_3_odt40 (Input), txbe_lpd4_3_odt60 (Input), txbe_lpd4_3_odtoff (Input)
