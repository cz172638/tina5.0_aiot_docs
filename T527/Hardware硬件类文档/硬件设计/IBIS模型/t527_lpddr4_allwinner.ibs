[IBIS ver] 5.0
[File name]  t527_lpddr4_allwinner.ibs
[File Rev]  1.0
[Date]   May 10, 2022
|   Component IO_LPDDR4
[Component] IO_LPDDR4
[Manufacturer] allwinner
[Package]
| variable   typ   min   max
R_pkg   0.0   0.0   0.0
L_pkg   0.0H   0.0H   0.0H
C_pkg   0.0F   0.0F   0.0F
[Pin]  signal_name   model_name   R_pin   L_pin   C_pin
AK33	SA0	CA_LPDDR4	0.46485	3.05E-09	1.51E-12
AG30	SA1	CA_LPDDR4	0.29715	2.09E-09	1.18E-12
AJ33	SA2	CA_LPDDR4	0.41469	2.81E-09	1.29E-12
AL27	SA3	CA_LPDDR4	0.39476	2.64E-09	1.37E-12
AH25	SA4	CA_LPDDR4	0.26569	1.83E-09	1.18E-12
AK27	SA5	CA_LPDDR4	0.32888	2.30E-09	1.35E-12
AN27	SA6	CA_LPDDR4	0.44924	3.13E-09	1.41E-12
AM33	SA7	CA_LPDDR4	0.56341	3.55E-09	1.70E-12
AL25	SA8	CA_LPDDR4	0.37181	2.57E-09	1.30E-12
AJ31	SA9	CA_LPDDR4	0.35333	2.55E-09	1.35E-12
AG29	SA10	CA_LPDDR4	0.25993	1.77E-09	1.12E-12
AJ32	SA11	CA_LPDDR4	0.39611	2.51E-09	1.34E-12
AL31	SA12	CA_LPDDR4	0.44743	2.77E-09	1.52E-12
AK29	SA13	CA_LPDDR4	0.35872	2.57E-09	1.27E-12
AM28	SA14	CA_LPDDR4	0.39678	2.69E-09	1.41E-12
AN29	SA15	CA_LPDDR4	0.49091	3.23E-09	1.49E-12
AJ27	SA16	CA_LPDDR4	0.29463	1.99E-09	1.15E-12
AJ30	SA17	CA_LPDDR4	0.37981	2.66E-09	1.46E-12
AL29	SACT	CA_LPDDR4	0.39833	2.73E-09	1.39E-12
AK25	SBA0	CA_LPDDR4	0.30769	2.31E-09	1.27E-12
AJ25	SBA1	CA_LPDDR4	0.28737	2.13E-09	1.22E-12
AN26	SBG0	CA_LPDDR4	0.41285	2.93E-09	1.40E-12
AM27	SBG1	CA_LPDDR4	0.39343	2.72E-09	1.37E-12
AM31	SCKE0	CA_LPDDR4	0.48683	2.99E-09	1.55E-12
AN30	SCKN	CA_LPDDR4	0.54668	3.52E-09	1.75E-12
AM30	SCKP	CA_LPDDR4	0.56055	3.52E-09	1.79E-12
AN32	SCS0	CA_LPDDR4	0.547	3.48E-09	1.70E-12
AM32	SCS1	CA_LPDDR4	0.49003	3.16E-09	1.61E-12
AL32	SODT0	CA_LPDDR4	0.45306	2.93E-09	1.55E-12
AL33	SODT1	CA_LPDDR4	0.50697	3.45E-09	1.63E-12
AE28	SDQ0	DQ_LPDDR4	0.17568	1.28E-09	8.75E-13
AE27	SDQ1	DQ_LPDDR4	0.1304	1.08E-09	7.74E-13
AG32	SDQ2	DQ_LPDDR4	0.33905	2.32E-09	1.24E-12
AH33	SDQ3	DQ_LPDDR4	0.39769	2.70E-09	1.33E-12
AE30	SDQ4	DQ_LPDDR4	0.28178	1.91E-09	1.10E-12
AD32	SDQ5	DQ_LPDDR4	0.321	2.18E-09	1.25E-12
AE31	SDQ6	DQ_LPDDR4	0.29187	2.02E-09	1.25E-12
AD33	SDQ7	DQ_LPDDR4	0.37551	2.47E-09	1.28E-12
AC27	SDQ8	DQ_LPDDR4	0.14886	1.15E-09	8.01E-13
AC28	SDQ9	DQ_LPDDR4	0.17895	1.33E-09	8.71E-13
AC30	SDQ10	DQ_LPDDR4	0.2394	1.64E-09	9.79E-13
AC31	SDQ11	DQ_LPDDR4	0.28218	1.96E-09	1.10E-12
AA33	SDQ12	DQ_LPDDR4	0.36554	2.31E-09	1.30E-12
AA31	SDQ13	DQ_LPDDR4	0.30839	2.01E-09	1.17E-12
AA28	SDQ14	DQ_LPDDR4	0.15212	1.33E-09	7.90E-13
AA27	SDQ15	DQ_LPDDR4	0.12387	1.09E-09	8.46E-13
AM25	SDQ16	DQ_LPDDR4	0.38757	2.65E-09	1.42E-12
AN25	SDQ17	DQ_LPDDR4	0.42985	2.80E-09	1.31E-12
AH23	SDQ18	DQ_LPDDR4	0.23213	1.61E-09	1.01E-12
AK23	SDQ19	DQ_LPDDR4	0.2673	1.84E-09	1.09E-12
AL23	SDQ20	DQ_LPDDR4	0.31232	2.08E-09	1.19E-12
AM22	SDQ21	DQ_LPDDR4	0.36632	2.33E-09	1.35E-12
AN21	SDQ22	DQ_LPDDR4	0.40833	2.68E-09	1.35E-12
AG21	SDQ23	DQ_LPDDR4	0.19578	1.35E-09	8.93E-13
AG19	SDQ24	DQ_LPDDR4	0.16051	1.30E-09	9.01E-13
AH19	SDQ25	DQ_LPDDR4	0.21804	1.52E-09	9.58E-13
AK19	SDQ26	DQ_LPDDR4	0.30686	2.04E-09	1.15E-12
AL19	SDQ27	DQ_LPDDR4	0.32712	2.27E-09	1.20E-12
AM21	SDQ28	DQ_LPDDR4	0.34396	2.30E-09	1.28E-12
AL21	SDQ29	DQ_LPDDR4	0.3528	2.39E-09	1.25E-12
AK21	SDQ30	DQ_LPDDR4	0.28636	1.94E-09	1.13E-12
AH21	SDQ31	DQ_LPDDR4	0.24326	1.59E-09	1.01E-12
AE33	SDQM0	DQ_LPDDR4	0.34788	2.43E-09	1.21E-12
AC32	SDQM1	DQ_LPDDR4	0.3269	2.19E-09	1.20E-12
AM24	SDQM2	DQ_LPDDR4	0.43004	2.77E-09	1.41E-12
AN20	SDQM3	DQ_LPDDR4	0.40177	2.76E-09	1.35E-12
AF33	SDQS0N	DQ_LPDDR4	0.39941	2.68E-09	1.37E-12
AF32	SDQS0P	DQ_LPDDR4	0.38352	2.63E-09	1.39E-12
AB33	SDQS1N	DQ_LPDDR4	0.39373	2.57E-09	1.37E-12
AB32	SDQS1P	DQ_LPDDR4	0.37061	2.44E-09	1.35E-12
AN23	SDQS2N	DQ_LPDDR4	0.42279	2.70E-09	1.46E-12
AM23	SDQS2P	DQ_LPDDR4	0.4289	2.74E-09	1.46E-12
AN19	SDQS3N	DQ_LPDDR4	0.43012	2.82E-09	1.45E-12
AM19	SDQS3P	DQ_LPDDR4	0.43756	2.88E-09	1.47E-12
[Model Selector] DQ_LPDDR4
DQ_PD33_ODT40_VOH25_LPDDR4 pull-down drive strength 33 Ohm,
DQ_PD40_ODT40_VOH25_LPDDR4 pull-down drive strength 40 Ohm,
DQ_PD48_ODT40_VOH25_LPDDR4 pull-down drive strength 48 Ohm,
DQ_PD58_ODT40_VOH25_LPDDR4 pull-down drive strength 58 Ohm,
DQ_PD75_ODT40_VOH25_LPDDR4 pull-down drive strength 75 Ohm,
DQ_PD132_ODT40_VOH25_LPDDR4 pull-down drive strength 132 Ohm,
DQ_PD265_ODT40_VOH25_LPDDR4 pull-down drive strength 265 Ohm,
DQ_PD33_ODT40_VOH30_LPDDR4 pull-down drive strength 33 Ohm,
DQ_PD40_ODT40_VOH30_LPDDR4 pull-down drive strength 40 Ohm,
DQ_PD48_ODT40_VOH30_LPDDR4 pull-down drive strength 48 Ohm,
DQ_PD58_ODT40_VOH30_LPDDR4 pull-down drive strength 58 Ohm,
DQ_PD75_ODT40_VOH30_LPDDR4 pull-down drive strength 75 Ohm,
DQ_PD132_ODT40_VOH30_LPDDR4 pull-down drive strength 132 Ohm,
DQ_PD265_ODT40_VOH30_LPDDR4 pull-down drive strength 265 Ohm,
DQ_PD33_ODT60_VOH25_LPDDR4 pull-down drive strength 33 Ohm,
DQ_PD40_ODT60_VOH25_LPDDR4 pull-down drive strength 40 Ohm,
DQ_PD48_ODT60_VOH25_LPDDR4 pull-down drive strength 48 Ohm,
DQ_PD58_ODT60_VOH25_LPDDR4 pull-down drive strength 58 Ohm,
DQ_PD75_ODT60_VOH25_LPDDR4 pull-down drive strength 75 Ohm,
DQ_PD132_ODT60_VOH25_LPDDR4 pull-down drive strength 132 Ohm,
DQ_PD265_ODT60_VOH25_LPDDR4 pull-down drive strength 265 Ohm,
DQ_PD33_ODT60_VOH30_LPDDR4 pull-down drive strength 33 Ohm,
DQ_PD40_ODT60_VOH30_LPDDR4 pull-down drive strength 40 Ohm,
DQ_PD48_ODT60_VOH30_LPDDR4 pull-down drive strength 48 Ohm,
DQ_PD58_ODT60_VOH30_LPDDR4 pull-down drive strength 58 Ohm,
DQ_PD75_ODT60_VOH30_LPDDR4 pull-down drive strength 75 Ohm,
DQ_PD132_ODT60_VOH30_LPDDR4 pull-down drive strength 132 Ohm,
DQ_PD265_ODT60_VOH30_LPDDR4 pull-down drive strength 265 Ohm,
DQ_ODT_PD132_LPDDR4 pulldn ODT resistance is  132 ohm
DQ_ODT_PD75_LPDDR4 pulldn ODT resistance is  75 ohm
DQ_ODT_PD58_LPDDR4 pulldn ODT resistance is  58 ohm
DQ_ODT_PD40_LPDDR4 pulldn ODT resistance is  40 ohm
[Model Selector] CA_LPDDR4
CA_PD33_ODT40_VOH25_LPDDR4 pull-down drive strength 33 Ohm,
CA_PD40_ODT40_VOH25_LPDDR4 pull-down drive strength 40 Ohm,
CA_PD48_ODT40_VOH25_LPDDR4 pull-down drive strength 48 Ohm,
CA_PD58_ODT40_VOH25_LPDDR4 pull-down drive strength 58 Ohm,
CA_PD75_ODT40_VOH25_LPDDR4 pull-down drive strength 75 Ohm,
CA_PD132_ODT40_VOH25_LPDDR4 pull-down drive strength 132 Ohm,
CA_PD265_ODT40_VOH25_LPDDR4 pull-down drive strength 265 Ohm,
CA_PD33_ODT40_VOH30_LPDDR4 pull-down drive strength 33 Ohm,
CA_PD40_ODT40_VOH30_LPDDR4 pull-down drive strength 40 Ohm,
CA_PD48_ODT40_VOH30_LPDDR4 pull-down drive strength 48 Ohm,
CA_PD58_ODT40_VOH30_LPDDR4 pull-down drive strength 58 Ohm,
CA_PD75_ODT40_VOH30_LPDDR4 pull-down drive strength 75 Ohm,
CA_PD132_ODT40_VOH30_LPDDR4 pull-down drive strength 132 Ohm,
CA_PD265_ODT40_VOH30_LPDDR4 pull-down drive strength 265 Ohm,
CA_PD33_ODT60_VOH25_LPDDR4 pull-down drive strength 33 Ohm,
CA_PD40_ODT60_VOH25_LPDDR4 pull-down drive strength 40 Ohm,
CA_PD48_ODT60_VOH25_LPDDR4 pull-down drive strength 48 Ohm,
CA_PD58_ODT60_VOH25_LPDDR4 pull-down drive strength 58 Ohm,
CA_PD75_ODT60_VOH25_LPDDR4 pull-down drive strength 75 Ohm,
CA_PD132_ODT60_VOH25_LPDDR4 pull-down drive strength 132 Ohm,
CA_PD265_ODT60_VOH25_LPDDR4 pull-down drive strength 265 Ohm,
CA_PD33_ODT60_VOH30_LPDDR4 pull-down drive strength 33 Ohm,
CA_PD40_ODT60_VOH30_LPDDR4 pull-down drive strength 40 Ohm,
CA_PD48_ODT60_VOH30_LPDDR4 pull-down drive strength 48 Ohm,
CA_PD58_ODT60_VOH30_LPDDR4 pull-down drive strength 58 Ohm,
CA_PD75_ODT60_VOH30_LPDDR4 pull-down drive strength 75 Ohm,
CA_PD132_ODT60_VOH30_LPDDR4 pull-down drive strength 132 Ohm,
CA_PD265_ODT60_VOH30_LPDDR4 pull-down drive strength 265 Ohm,
| Models and submodels in the file (60): DQ_PD33_ODT40_VOH25_LPDDR4 (I/O), DQ_PD40_ODT40_VOH25_LPDDR4 (I/O), DQ_PD48_ODT40_VOH25_LPDDR4 (I/O), DQ_PD58_ODT40_VOH25_LPDDR4 (I/O), DQ_PD75_ODT40_VOH25_LPDDR4 (I/O), DQ_PD132_ODT40_VOH25_LPDDR4 (I/O), DQ_PD265_ODT40_VOH25_LPDDR4 (I/O), DQ_PD33_ODT40_VOH30_LPDDR4 (I/O), DQ_PD40_ODT40_VOH30_LPDDR4 (I/O), DQ_PD48_ODT40_VOH30_LPDDR4 (I/O), DQ_PD58_ODT40_VOH30_LPDDR4 (I/O), DQ_PD75_ODT40_VOH30_LPDDR4 (I/O), DQ_PD132_ODT40_VOH30_LPDDR4 (I/O), DQ_PD265_ODT40_VOH30_LPDDR4 (I/O), DQ_PD33_ODT60_VOH25_LPDDR4 (I/O), DQ_PD40_ODT60_VOH25_LPDDR4 (I/O), DQ_PD48_ODT60_VOH25_LPDDR4 (I/O), DQ_PD58_ODT60_VOH25_LPDDR4 (I/O), DQ_PD75_ODT60_VOH25_LPDDR4 (I/O), DQ_PD132_ODT60_VOH25_LPDDR4 (I/O), DQ_PD265_ODT60_VOH25_LPDDR4 (I/O), DQ_PD33_ODT60_VOH30_LPDDR4 (I/O), DQ_PD40_ODT60_VOH30_LPDDR4 (I/O), DQ_PD48_ODT60_VOH30_LPDDR4 (I/O), DQ_PD58_ODT60_VOH30_LPDDR4 (I/O), DQ_PD75_ODT60_VOH30_LPDDR4 (I/O), DQ_PD132_ODT60_VOH30_LPDDR4 (I/O), DQ_PD265_ODT60_VOH30_LPDDR4 (I/O), DQ_ODT_PD132_LPDDR4 (Input), DQ_ODT_PD75_LPDDR4 (Input), DQ_ODT_PD58_LPDDR4 (Input), DQ_ODT_PD40_LPDDR4 (Input), CA_PD33_ODT40_VOH25_LPDDR4 (3-state), CA_PD40_ODT40_VOH25_LPDDR4 (3-state), CA_PD48_ODT40_VOH25_LPDDR4 (3-state), CA_PD58_ODT40_VOH25_LPDDR4 (3-state), CA_PD75_ODT40_VOH25_LPDDR4 (3-state), CA_PD132_ODT40_VOH25_LPDDR4 (3-state), CA_PD265_ODT40_VOH25_LPDDR4 (3-state), CA_PD33_ODT40_VOH30_LPDDR4 (3-state), CA_PD40_ODT40_VOH30_LPDDR4 (3-state), CA_PD48_ODT40_VOH30_LPDDR4 (3-state), CA_PD58_ODT40_VOH30_LPDDR4 (3-state), CA_PD75_ODT40_VOH30_LPDDR4 (3-state), CA_PD132_ODT40_VOH30_LPDDR4 (3-state), CA_PD265_ODT40_VOH30_LPDDR4 (3-state), CA_PD33_ODT60_VOH25_LPDDR4 (3-state), CA_PD40_ODT60_VOH25_LPDDR4 (3-state), CA_PD48_ODT60_VOH25_LPDDR4 (3-state), CA_PD58_ODT60_VOH25_LPDDR4 (3-state), CA_PD75_ODT60_VOH25_LPDDR4 (3-state), CA_PD132_ODT60_VOH25_LPDDR4 (3-state), CA_PD265_ODT60_VOH25_LPDDR4 (3-state), CA_PD33_ODT60_VOH30_LPDDR4 (3-state), CA_PD40_ODT60_VOH30_LPDDR4 (3-state), CA_PD48_ODT60_VOH30_LPDDR4 (3-state), CA_PD58_ODT60_VOH30_LPDDR4 (3-state), CA_PD75_ODT60_VOH30_LPDDR4 (3-state), CA_PD132_ODT60_VOH30_LPDDR4 (3-state), CA_PD265_ODT60_VOH30_LPDDR4 (3-state)
